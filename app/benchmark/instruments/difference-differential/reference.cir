Circuit Lab · Differenze libero
* ngspice subset: generated from explicit connections; no hidden ground or leakage.
* Transient initial conditions require UIC. DC bias is separate from the waveform.
* CLAB_OUT N7
* CLAB_IN N3
V_V1 N1 N2 DC 0.000000000000000e+0 AC 5.000000000000000e-1 1.800000000000000e+2 SIN(0.000000000000000e+0 -2.500000000000000e-1 1.000000000000000e+3 0 0 0.000000000000000e+0)
R_R1 N3 N4 1.000000000000000e+4
C_U1state Z_U1 0 7.957747154594767e-3 IC=0.000000000000000e+0
B_U1state Z_U1 0 I=-(v(Z_U1)>=1.350000000000000e+1 ? min(0,(2.000000000000000e+5*(v(N5)-v(N6))-v(Z_U1)))-(v(Z_U1)-1.350000000000000e+1) : (v(Z_U1)<=-1.350000000000000e+1 ? max(0,(2.000000000000000e+5*(v(N5)-v(N6))-v(Z_U1)))-(v(Z_U1)--1.350000000000000e+1) : (2.000000000000000e+5*(v(N5)-v(N6))-v(Z_U1))))
E_U1out N7 0 Z_U1 0 1
R_Rf N8 N9 4.700000000000000e+4
V_V2 N10 N11 DC 0.000000000000000e+0 AC 5.000000000000000e-1 0.000000000000000e+0 SIN(0.000000000000000e+0 2.500000000000000e-1 1.000000000000000e+3 0 0 0.000000000000000e+0)
R_R3 N12 N13 1.000000000000000e+4
R_R4 N14 N15 4.747000000000000e+4
R_RG1 N1 N16 5.000000000000000e+1
R_RG2 N10 N17 5.000000000000000e+1
R_RW1 N16 N3 5.000000000000000e-2
R_RW2 N2 0 5.000000000000000e-2
R_RW3 N6 N8 5.000000000000000e-2
R_RW4 N9 N7 5.000000000000000e-2
R_RW5 N4 N6 5.000000000000000e-2
R_RW6 N17 N12 5.000000000000000e-2
R_RW7 N13 N5 5.000000000000000e-2
R_RW8 N13 N14 5.000000000000000e-2
R_RW9 N15 0 5.000000000000000e-2
R_RW10 N11 0 5.000000000000000e-2
C_CC1 N3 0 9.000000000000000e-11 IC=0.000000000000000e+0
R_RO1 N3 0 1.000000000000000e+6
C_CO1 N3 0 2.000000000000000e-11 IC=0.000000000000000e+0
C_CC2 N7 0 9.000000000000000e-11 IC=0.000000000000000e+0
R_RO2 N7 0 1.000000000000000e+6
C_CO2 N7 0 2.000000000000000e-11 IC=0.000000000000000e+0
* Model definitions are generic; original JSON is needed for full editing and measurement data.
.options reltol=1e-10 abstol=1e-14 vntol=1e-12
.control
set wr_singlescale
set wr_vecnames
set numdgt=15
ac dec 20 .1 1000000
wrdata reference.dat real(v(N7)) imag(v(N7)) real(v(N3)) imag(v(N3))
quit
.endc
.end
