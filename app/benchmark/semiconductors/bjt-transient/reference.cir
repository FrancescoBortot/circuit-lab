Circuit Lab · BJT NPN · emettitore comune
* ngspice subset: generated from explicit connections; no hidden ground or leakage.
* Transient initial conditions require UIC. DC bias is separate from the waveform.
* CLAB_OUT N3
* CLAB_IN N1
V_V1 N1 0 DC 7.000000000000000e-1 AC 1.000000000000000e+0 0.000000000000000e+0 SIN(7.000000000000000e-1 1.000000000000000e-2 1.000000000000000e+3 0 0 0.000000000000000e+0)
V_Vcc N2 0 DC 5.000000000000000e+0 AC 0.000000000000000e+0 0.000000000000000e+0 PWL(0 5.000000000000000e+0 3.000000000000000e-3 5.000000000000000e+0)
R_R1 N2 N3 1.000000000000000e+3
Q_Q1 N3 N4 0 Model_Q1
.model Model_Q1 NPN(IS=1.000000000000000e-14 BF=1.000000000000000e+2 BR=1.000000000000000e+0 TNOM=27)
R_Rb N1 N4 1.000000000000000e+4
C_LoadC N3 0 1.000000000000000e-8 IC=4.413269769030230e+0
.temp 27
* Model definitions are generic; original JSON is needed for full editing and measurement data.
.options reltol=1e-10 abstol=1e-14 vntol=1e-12 gmin=1e-18
.control
set wr_singlescale
set wr_vecnames
set numdgt=15
tran 6e-8 0.003 0 6e-8 uic
wrdata reference.dat v(N3)
quit
.endc
.end
