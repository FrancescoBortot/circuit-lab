Circuit Lab · RC libero
* ngspice subset: generated from explicit connections; no hidden ground or leakage.
* Transient initial conditions require UIC. DC bias is separate from the waveform.
* CLAB_OUT N2
* CLAB_IN N1
V_V1 N1 0 DC 0.000000000000000e+0 AC 1.000000000000000e+0 0.000000000000000e+0 PWL(0 5.000000000000000e+0 6.000000000000000e-3 5.000000000000000e+0)
R_R1 N1 N2 1.000000000000000e+4
R_C1 N2 0 2.000000000000000e+4
* Model definitions are generic; original JSON is needed for full editing and measurement data.
.options reltol=1e-9 abstol=1e-13 vntol=1e-11
.control
set wr_singlescale
set wr_vecnames
set numdgt=15
dc V_V1 -5 5 0.1
wrdata reference.dat v(N2)
quit
.endc
.end
