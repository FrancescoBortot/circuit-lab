Circuit Lab · Differenze libero
* ngspice subset: generated from explicit connections; no hidden ground or leakage.
* Transient initial conditions require UIC. DC bias is separate from the waveform.
* CLAB_OUT N4
* CLAB_IN N1
V_V1 N1 0 DC 0.000000000000000e+0 AC 5.000000000000000e-1 1.950000000000000e+2 SIN(0.000000000000000e+0 5.000000000000000e-1 1.000000000000000e+3 0 0 0.000000000000000e+0)
R_R1 N1 N2 1.000000000000000e+4
C_U1state Z_U1 0 7.957747154594767e-3 IC=0.000000000000000e+0
B_U1state Z_U1 0 I=-(v(Z_U1)>=1.350000000000000e+1 ? min(0,(2.000000000000000e+5*(v(N3)-v(N2))-v(Z_U1)))-(v(Z_U1)-1.350000000000000e+1) : (v(Z_U1)<=-1.350000000000000e+1 ? max(0,(2.000000000000000e+5*(v(N3)-v(N2))-v(Z_U1)))-(v(Z_U1)--1.350000000000000e+1) : (2.000000000000000e+5*(v(N3)-v(N2))-v(Z_U1))))
E_U1out N4 0 Z_U1 0 1
R_Rf N2 N4 4.700000000000000e+4
V_V2 N5 0 DC 0.000000000000000e+0 AC 5.000000000000000e-1 1.500000000000000e+1 PWL(0.000000000000000e+0 1.000000000000000e+0 5.000000000000000e-3 1.000000000000000e+0 5.000000000000000e-3 -1.000000000000000e+0 1.000000000000000e-2 -1.000000000000000e+0 1.000000000000000e-2 1.000000000000000e+0 1.500000000000000e-2 1.000000000000000e+0 1.500000000000000e-2 -1.000000000000000e+0 2.000000000000000e-2 -1.000000000000000e+0 2.000000000000000e-2 1.000000000000000e+0)
R_R3 N5 N3 1.000000000000000e+4
R_R4 N3 0 4.700000000000000e+4
* Model definitions are generic; original JSON is needed for full editing and measurement data.
.options reltol=1e-9 abstol=1e-13 vntol=1e-11
.control
set wr_singlescale
set wr_vecnames
set numdgt=15
ac oct 8 10 100000
wrdata reference.dat real(v(N4)) imag(v(N4))
quit
.endc
.end
