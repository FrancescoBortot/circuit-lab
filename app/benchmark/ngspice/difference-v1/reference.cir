Circuit Lab independent ngspice reference
V_V1 N1 0 DC 0 AC 1
R_R1 N1 N2 10000
EU1a U1drive 0 N3 N2 200000
RU1pole U1drive U1pole 1
CU1pole U1pole 0 0.007957747154594767 IC=0
EU1buffer N4 0 U1pole 0 1
R_Rf N2 N4 47000
V_V2 N5 0 DC 0 AC 0
R_R3 N5 N3 10000
R_R4 N3 0 47000
.options reltol=1e-9 abstol=1e-13 vntol=1e-11
.control
set wr_singlescale
set wr_vecnames
set numdgt=15
ac dec 50 1 1e6
wrdata reference.dat real(v(N4)) imag(v(N4))
quit
.endc
.end
