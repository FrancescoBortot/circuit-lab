Circuit Lab independent ngspice reference
V_V1 N1 0 DC 5 AC 1
R_R1 N1 N2 100
C_C1 N3 0 0.000001 IC=0
L_L1 N2 N3 0.01 IC=0
.options reltol=1e-9 abstol=1e-13 vntol=1e-11
.control
set wr_singlescale
set wr_vecnames
set numdgt=15
tran 1e-7 0.002 0 1e-7 uic
wrdata reference.dat v(N3) v(N1)
quit
.endc
.end
