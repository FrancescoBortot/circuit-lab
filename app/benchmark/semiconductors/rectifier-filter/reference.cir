Circuit Lab · Raddrizzatore a diodo con filtro RC
* ngspice subset: generated from explicit connections; no hidden ground or leakage.
* Transient initial conditions require UIC. DC bias is separate from the waveform.
* CLAB_OUT N2
* CLAB_IN N1
V_V1 N1 0 DC 0.000000000000000e+0 AC 1.000000000000000e+0 0.000000000000000e+0 SIN(0.000000000000000e+0 5.000000000000000e+0 5.000000000000000e+1 0 0 0.000000000000000e+0)
D_D1 N1 N2 Model_D1
.model Model_D1 D(IS=3.500000000000000e-11 N=1.500000000000000e+0 TNOM=27)
R_R1 N2 0 1.000000000000000e+4
C_C1 N2 0 1.000000000000000e-5 IC=0.000000000000000e+0
.temp 27
* Model definitions are generic; original JSON is needed for full editing and measurement data.
.options reltol=1e-10 abstol=1e-14 vntol=1e-12 gmin=1e-18
.control
set wr_singlescale
set wr_vecnames
set numdgt=15
tran 0.0000016 0.08 0 0.0000016 uic
wrdata reference.dat v(N2)
quit
.endc
.end
